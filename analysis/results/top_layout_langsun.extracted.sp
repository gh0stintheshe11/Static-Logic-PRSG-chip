* Extracted from 12_ELEC4609_FALL2022/12_ELEC4609_FALL2022.gds with KLayout (flat, MOS3, lengths in um)

* cell top_layout_langsun
* pin C1
* pin C2
* pin MINIPAD
* pin RST
* pin VDD
* pin VSS
* pin Vo
.SUBCKT top_layout_langsun C1 C2 MINIPAD RST VDD VSS Vo
* device instance $1 r0 *1 506.4,-427.2 MN
M$1 VSS MINIPAD Vo Vo MN L=4.8U W=321.6U AS=1820.16P AD=1290.24P PS=499.2U
+ PD=422.4U
* device instance $2 r0 *1 48,-187.2 MN
M$2 VSS VSS C2 C2 MN L=4.8U W=220.8U AS=2188.8P AD=944.64P PS=873.6U PD=254.4U
* device instance $3 r0 *1 48,-148.8 MN
M$3 C1 VSS VSS VSS MN L=4.8U W=220.8U AS=944.64P AD=2188.8P PS=254.4U PD=873.6U
* device instance $4 m45 *1 480,-187.2 MN
M$4 RST VSS VSS VSS MN L=4.8U W=220.8U AS=1313.28P AD=2188.8P PS=340.8U
+ PD=873.6U
* device instance $5 m0 *1 196.8,-408 MN
M$5 \$I10 \$7 VSS VSS MN L=4.8U W=4.8U AS=103.68P AD=11.52P PS=43.2U PD=9.6U
* device instance $6 m0 *1 206.4,-408 MN
M$6 \$I10 \$I9 \$I7 \$I7 MN L=4.8U W=4.8U AS=103.68P AD=11.52P PS=43.2U PD=9.6U
* device instance $7 m0 *1 196.8,-427.2 MP
M$7 \$I7 \$7 VDD VDD MP L=4.8U W=9.6U AS=115.2P AD=69.12P PS=43.2U PD=24U
* device instance $8 m0 *1 216,-427.2 MP
M$8 VDD \$I9 \$I7 \$I7 MP L=4.8U W=9.6U AS=69.12P AD=115.2P PS=24U PD=43.2U
* device instance $9 m0 *1 254.4,-408 MN
M$9 \$I11 \$I7 VSS VSS MN L=4.8U W=4.8U AS=103.68P AD=11.52P PS=43.2U PD=9.6U
* device instance $10 m0 *1 264,-408 MN
M$10 \$I11 \$8 \$I8 \$I8 MN L=4.8U W=4.8U AS=103.68P AD=11.52P PS=43.2U PD=9.6U
* device instance $11 m0 *1 254.4,-427.2 MP
M$11 \$I8 \$I7 VDD VDD MP L=4.8U W=9.6U AS=115.2P AD=69.12P PS=43.2U PD=24U
* device instance $12 m0 *1 273.6,-427.2 MP
M$12 VDD \$8 \$I8 \$I8 MP L=4.8U W=9.6U AS=69.12P AD=115.2P PS=24U PD=43.2U
* device instance $13 m0 *1 316.8,-408 MN
M$13 \$I12 \$I2 VSS VSS MN L=4.8U W=4.8U AS=103.68P AD=11.52P PS=43.2U PD=9.6U
* device instance $14 m0 *1 326.4,-408 MN
M$14 \$I12 \$I5 \$I6 \$I6 MN L=4.8U W=4.8U AS=103.68P AD=11.52P PS=43.2U PD=9.6U
* device instance $15 m0 *1 316.8,-427.2 MP
M$15 \$I6 \$I2 VDD VDD MP L=4.8U W=9.6U AS=115.2P AD=69.12P PS=43.2U PD=24U
* device instance $16 m0 *1 336,-427.2 MP
M$16 VDD \$I5 \$I6 \$I6 MP L=4.8U W=9.6U AS=69.12P AD=115.2P PS=24U PD=43.2U
* device instance $17 m0 *1 374.4,-408 MN
M$17 \$I13 \$I6 VSS VSS MN L=4.8U W=4.8U AS=103.68P AD=11.52P PS=43.2U PD=9.6U
* device instance $18 m0 *1 384,-408 MN
M$18 \$I13 \$I1 \$I4 \$I4 MN L=4.8U W=4.8U AS=103.68P AD=11.52P PS=43.2U PD=9.6U
* device instance $19 m0 *1 374.4,-427.2 MP
M$19 \$I4 \$I6 VDD VDD MP L=4.8U W=9.6U AS=115.2P AD=69.12P PS=43.2U PD=24U
* device instance $20 m0 *1 393.6,-427.2 MP
M$20 VDD \$I1 \$I4 \$I4 MP L=4.8U W=9.6U AS=69.12P AD=115.2P PS=24U PD=43.2U
* device instance $21 r0 *1 374.4,-374.4 MN
M$21 \$I14 \$I5 VSS VSS MN L=4.8U W=4.8U AS=103.68P AD=11.52P PS=43.2U PD=9.6U
* device instance $22 r0 *1 384,-374.4 MN
M$22 \$I14 \$I4 \$I1 \$I1 MN L=4.8U W=4.8U AS=103.68P AD=11.52P PS=43.2U PD=9.6U
* device instance $23 r0 *1 374.4,-355.2 MP
M$23 \$I1 \$I5 VDD VDD MP L=4.8U W=9.6U AS=115.2P AD=69.12P PS=43.2U PD=24U
* device instance $24 r0 *1 393.6,-355.2 MP
M$24 VDD \$I4 \$I1 \$I1 MP L=4.8U W=9.6U AS=69.12P AD=115.2P PS=24U PD=43.2U
* device instance $25 r0 *1 316.8,-374.4 MN
M$25 \$I15 \$8 VSS VSS MN L=4.8U W=4.8U AS=103.68P AD=11.52P PS=43.2U PD=9.6U
* device instance $26 r0 *1 326.4,-374.4 MN
M$26 \$I15 \$I2 \$I5 \$I5 MN L=4.8U W=4.8U AS=103.68P AD=11.52P PS=43.2U PD=9.6U
* device instance $27 r0 *1 316.8,-355.2 MP
M$27 \$I5 \$8 VDD VDD MP L=4.8U W=9.6U AS=115.2P AD=69.12P PS=43.2U PD=24U
* device instance $28 r0 *1 336,-355.2 MP
M$28 VDD \$I2 \$I5 \$I5 MP L=4.8U W=9.6U AS=69.12P AD=115.2P PS=24U PD=43.2U
* device instance $29 r0 *1 254.4,-374.4 MN
M$29 \$I16 \$I9 VSS VSS MN L=4.8U W=4.8U AS=103.68P AD=11.52P PS=43.2U PD=9.6U
* device instance $30 r0 *1 264,-374.4 MN
M$30 \$I16 \$I8 \$8 \$8 MN L=4.8U W=4.8U AS=103.68P AD=11.52P PS=43.2U PD=9.6U
* device instance $31 r0 *1 254.4,-355.2 MP
M$31 \$8 \$I9 VDD VDD MP L=4.8U W=9.6U AS=115.2P AD=69.12P PS=43.2U PD=24U
* device instance $32 r0 *1 273.6,-355.2 MP
M$32 VDD \$I8 \$8 \$8 MP L=4.8U W=9.6U AS=69.12P AD=115.2P PS=24U PD=43.2U
* device instance $33 r0 *1 196.8,-374.4 MN
M$33 \$I17 \$11 VSS VSS MN L=4.8U W=4.8U AS=103.68P AD=11.52P PS=43.2U PD=9.6U
* device instance $34 r0 *1 206.4,-374.4 MN
M$34 \$I17 \$7 \$I9 \$I9 MN L=4.8U W=4.8U AS=103.68P AD=11.52P PS=43.2U PD=9.6U
* device instance $35 r0 *1 196.8,-355.2 MP
M$35 \$I9 \$11 VDD VDD MP L=4.8U W=9.6U AS=115.2P AD=69.12P PS=43.2U PD=24U
* device instance $36 r0 *1 216,-355.2 MP
M$36 VDD \$7 \$I9 \$I9 MP L=4.8U W=9.6U AS=69.12P AD=115.2P PS=24U PD=43.2U
* device instance $37 m90 *1 158.4,-374.4 MN
M$37 \$7 \$24 VSS VSS MN L=4.8U W=4.8U AS=103.68P AD=103.68P PS=43.2U PD=43.2U
* device instance $38 m90 *1 158.4,-352.8 MP
M$38 \$7 \$24 VDD VDD MP L=4.8U W=9.6U AS=115.2P AD=115.2P PS=43.2U PD=43.2U
* device instance $39 r180 *1 158.4,-405.6 MN
M$39 \$I2 \$7 VSS VSS MN L=4.8U W=4.8U AS=103.68P AD=103.68P PS=43.2U PD=43.2U
* device instance $40 r180 *1 158.4,-427.2 MP
M$40 \$I2 \$7 VDD VDD MP L=4.8U W=9.6U AS=115.2P AD=115.2P PS=43.2U PD=43.2U
* device instance $41 m0 *1 196.8,-194.4 MN
M$41 \$I24 \$20 VSS VSS MN L=4.8U W=4.8U AS=103.68P AD=11.52P PS=43.2U PD=9.6U
* device instance $42 m0 *1 206.4,-194.4 MN
M$42 \$I24 \$I23 \$I21 \$I21 MN L=4.8U W=4.8U AS=103.68P AD=11.52P PS=43.2U
+ PD=9.6U
* device instance $43 m0 *1 196.8,-213.6 MP
M$43 \$I21 \$20 VDD VDD MP L=4.8U W=9.6U AS=115.2P AD=69.12P PS=43.2U PD=24U
* device instance $44 m0 *1 216,-213.6 MP
M$44 VDD \$I23 \$I21 \$I21 MP L=4.8U W=9.6U AS=69.12P AD=115.2P PS=24U PD=43.2U
* device instance $45 m0 *1 254.4,-194.4 MN
M$45 \$I25 \$I21 VSS VSS MN L=4.8U W=4.8U AS=103.68P AD=11.52P PS=43.2U PD=9.6U
* device instance $46 m0 *1 264,-194.4 MN
M$46 \$I25 \$21 \$I22 \$I22 MN L=4.8U W=4.8U AS=103.68P AD=11.52P PS=43.2U
+ PD=9.6U
* device instance $47 m0 *1 254.4,-213.6 MP
M$47 \$I22 \$I21 VDD VDD MP L=4.8U W=9.6U AS=115.2P AD=69.12P PS=43.2U PD=24U
* device instance $48 m0 *1 273.6,-213.6 MP
M$48 VDD \$21 \$I22 \$I22 MP L=4.8U W=9.6U AS=69.12P AD=115.2P PS=24U PD=43.2U
* device instance $49 m0 *1 316.8,-194.4 MN
M$49 \$I26 \$22 VSS VSS MN L=4.8U W=4.8U AS=103.68P AD=11.52P PS=43.2U PD=9.6U
* device instance $50 m0 *1 326.4,-194.4 MN
M$50 \$I26 \$I19 \$I20 \$I20 MN L=4.8U W=4.8U AS=103.68P AD=11.52P PS=43.2U
+ PD=9.6U
* device instance $51 m0 *1 316.8,-213.6 MP
M$51 \$I20 \$22 VDD VDD MP L=4.8U W=9.6U AS=115.2P AD=69.12P PS=43.2U PD=24U
* device instance $52 m0 *1 336,-213.6 MP
M$52 VDD \$I19 \$I20 \$I20 MP L=4.8U W=9.6U AS=69.12P AD=115.2P PS=24U PD=43.2U
* device instance $53 m0 *1 374.4,-194.4 MN
M$53 \$I27 \$I20 VSS VSS MN L=4.8U W=4.8U AS=103.68P AD=11.52P PS=43.2U PD=9.6U
* device instance $54 m0 *1 384,-194.4 MN
M$54 \$I27 \$18 \$I18 \$I18 MN L=4.8U W=4.8U AS=103.68P AD=11.52P PS=43.2U
+ PD=9.6U
* device instance $55 m0 *1 374.4,-213.6 MP
M$55 \$I18 \$I20 VDD VDD MP L=4.8U W=9.6U AS=115.2P AD=69.12P PS=43.2U PD=24U
* device instance $56 m0 *1 393.6,-213.6 MP
M$56 VDD \$18 \$I18 \$I18 MP L=4.8U W=9.6U AS=69.12P AD=115.2P PS=24U PD=43.2U
* device instance $57 r0 *1 374.4,-160.8 MN
M$57 \$I28 \$I19 VSS VSS MN L=4.8U W=4.8U AS=103.68P AD=11.52P PS=43.2U PD=9.6U
* device instance $58 r0 *1 384,-160.8 MN
M$58 \$I28 \$I18 \$18 \$18 MN L=4.8U W=4.8U AS=103.68P AD=11.52P PS=43.2U
+ PD=9.6U
* device instance $59 r0 *1 374.4,-141.6 MP
M$59 \$18 \$I19 VDD VDD MP L=4.8U W=9.6U AS=115.2P AD=69.12P PS=43.2U PD=24U
* device instance $60 r0 *1 393.6,-141.6 MP
M$60 VDD \$I18 \$18 \$18 MP L=4.8U W=9.6U AS=69.12P AD=115.2P PS=24U PD=43.2U
* device instance $61 r0 *1 316.8,-160.8 MN
M$61 \$I29 \$21 VSS VSS MN L=4.8U W=4.8U AS=103.68P AD=11.52P PS=43.2U PD=9.6U
* device instance $62 r0 *1 326.4,-160.8 MN
M$62 \$I29 \$22 \$I19 \$I19 MN L=4.8U W=4.8U AS=103.68P AD=11.52P PS=43.2U
+ PD=9.6U
* device instance $63 r0 *1 316.8,-141.6 MP
M$63 \$I19 \$21 VDD VDD MP L=4.8U W=9.6U AS=115.2P AD=69.12P PS=43.2U PD=24U
* device instance $64 r0 *1 336,-141.6 MP
M$64 VDD \$22 \$I19 \$I19 MP L=4.8U W=9.6U AS=69.12P AD=115.2P PS=24U PD=43.2U
* device instance $65 r0 *1 254.4,-160.8 MN
M$65 \$I30 \$I23 VSS VSS MN L=4.8U W=4.8U AS=103.68P AD=11.52P PS=43.2U PD=9.6U
* device instance $66 r0 *1 264,-160.8 MN
M$66 \$I30 \$I22 \$21 \$21 MN L=4.8U W=4.8U AS=103.68P AD=11.52P PS=43.2U
+ PD=9.6U
* device instance $67 r0 *1 254.4,-141.6 MP
M$67 \$21 \$I23 VDD VDD MP L=4.8U W=9.6U AS=115.2P AD=69.12P PS=43.2U PD=24U
* device instance $68 r0 *1 273.6,-141.6 MP
M$68 VDD \$I22 \$21 \$21 MP L=4.8U W=9.6U AS=69.12P AD=115.2P PS=24U PD=43.2U
* device instance $69 r0 *1 196.8,-160.8 MN
M$69 \$I31 \$28 VSS VSS MN L=4.8U W=4.8U AS=103.68P AD=11.52P PS=43.2U PD=9.6U
* device instance $70 r0 *1 206.4,-160.8 MN
M$70 \$I31 \$20 \$I23 \$I23 MN L=4.8U W=4.8U AS=103.68P AD=11.52P PS=43.2U
+ PD=9.6U
* device instance $71 r0 *1 196.8,-141.6 MP
M$71 \$I23 \$28 VDD VDD MP L=4.8U W=9.6U AS=115.2P AD=69.12P PS=43.2U PD=24U
* device instance $72 r0 *1 216,-141.6 MP
M$72 VDD \$20 \$I23 \$I23 MP L=4.8U W=9.6U AS=69.12P AD=115.2P PS=24U PD=43.2U
* device instance $73 m90 *1 158.4,-160.8 MN
M$73 \$20 \$24 VSS VSS MN L=4.8U W=4.8U AS=103.68P AD=103.68P PS=43.2U PD=43.2U
* device instance $74 m90 *1 158.4,-139.2 MP
M$74 \$20 \$24 VDD VDD MP L=4.8U W=9.6U AS=115.2P AD=115.2P PS=43.2U PD=43.2U
* device instance $75 r180 *1 158.4,-192 MN
M$75 \$22 \$20 VSS VSS MN L=4.8U W=4.8U AS=103.68P AD=103.68P PS=43.2U PD=43.2U
* device instance $76 r180 *1 158.4,-213.6 MP
M$76 \$22 \$20 VDD VDD MP L=4.8U W=9.6U AS=115.2P AD=115.2P PS=43.2U PD=43.2U
* device instance $77 r0 *1 139.2,-57.6 MN
M$77 C1 VDD \$I32 \$I32 MN L=4.8U W=28.8U AS=345.6P AD=311.04P PS=96U PD=91.2U
* device instance $78 r0 *1 168,-55.2 MN
M$78 \$I33 C1 VSS VSS MN L=4.8U W=4.8U AS=103.68P AD=103.68P PS=43.2U PD=43.2U
* device instance $79 r0 *1 180,-33.6 MP
M$79 VDD C1 \$I33 \$I33 MP L=4.8U W=9.6U AS=115.2P AD=115.2P PS=43.2U PD=43.2U
* device instance $80 r180 *1 187.2,-88.8 MN
M$80 \$24 \$I32 VSS VSS MN L=4.8U W=4.8U AS=103.68P AD=103.68P PS=43.2U PD=43.2U
* device instance $81 r180 *1 175.2,-110.4 MP
M$81 VDD \$I32 \$24 \$24 MP L=4.8U W=9.6U AS=115.2P AD=115.2P PS=43.2U PD=43.2U
* device instance $82 r180 *1 235.2,-86.4 MN
M$82 \$I32 C2 VSS VSS MN L=4.8U W=4.8U AS=103.68P AD=103.68P PS=43.2U PD=43.2U
* device instance $83 r180 *1 223.2,-108 MP
M$83 VDD C2 \$I32 \$I32 MP L=4.8U W=9.6U AS=115.2P AD=115.2P PS=43.2U PD=43.2U
* device instance $84 r0 *1 216,-55.2 MN
M$84 C2 \$I33 VSS VSS MN L=4.8U W=4.8U AS=103.68P AD=103.68P PS=43.2U PD=43.2U
* device instance $85 r0 *1 228,-33.6 MP
M$85 VDD \$I33 C2 C2 MP L=4.8U W=9.6U AS=115.2P AD=115.2P PS=43.2U PD=43.2U
* device instance $86 r180 *1 168,-300 MN
M$86 \$I40 \$I36 VSS VSS MN L=4.8U W=4.8U AS=103.68P AD=11.52P PS=43.2U PD=9.6U
* device instance $87 r180 *1 158.4,-300 MN
M$87 \$I40 \$11 \$I34 \$I34 MN L=4.8U W=4.8U AS=103.68P AD=11.52P PS=43.2U
+ PD=9.6U
* device instance $88 r180 *1 168,-319.2 MP
M$88 \$I34 \$I36 VDD VDD MP L=4.8U W=9.6U AS=115.2P AD=69.12P PS=43.2U PD=24U
* device instance $89 r180 *1 148.8,-319.2 MP
M$89 VDD \$11 \$I34 \$I34 MP L=4.8U W=9.6U AS=69.12P AD=115.2P PS=24U PD=43.2U
* device instance $90 r180 *1 345.6,-300 MN
M$90 \$I41 \$15 VSS VSS MN L=4.8U W=4.8U AS=103.68P AD=11.52P PS=43.2U PD=9.6U
* device instance $91 r180 *1 336,-300 MN
M$91 \$I41 \$I39 \$I37 \$I37 MN L=4.8U W=4.8U AS=103.68P AD=11.52P PS=43.2U
+ PD=9.6U
* device instance $92 r180 *1 345.6,-319.2 MP
M$92 \$I37 \$15 VDD VDD MP L=4.8U W=9.6U AS=115.2P AD=69.12P PS=43.2U PD=24U
* device instance $93 r180 *1 326.4,-319.2 MP
M$93 VDD \$I39 \$I37 \$I37 MP L=4.8U W=9.6U AS=69.12P AD=115.2P PS=24U PD=43.2U
* device instance $94 r180 *1 288,-300 MN
M$94 \$I42 \$I37 VSS VSS MN L=4.8U W=4.8U AS=103.68P AD=11.52P PS=43.2U PD=9.6U
* device instance $95 r180 *1 278.4,-300 MN
M$95 \$I42 \$14 \$I38 \$I38 MN L=4.8U W=4.8U AS=103.68P AD=11.52P PS=43.2U
+ PD=9.6U
* device instance $96 r180 *1 288,-319.2 MP
M$96 \$I38 \$I37 VDD VDD MP L=4.8U W=9.6U AS=115.2P AD=69.12P PS=43.2U PD=24U
* device instance $97 r180 *1 268.8,-319.2 MP
M$97 VDD \$14 \$I38 \$I38 MP L=4.8U W=9.6U AS=69.12P AD=115.2P PS=24U PD=43.2U
* device instance $98 r180 *1 225.6,-300 MN
M$98 \$I43 \$13 VSS VSS MN L=4.8U W=4.8U AS=103.68P AD=11.52P PS=43.2U PD=9.6U
* device instance $99 r180 *1 216,-300 MN
M$99 \$I43 \$I35 \$I36 \$I36 MN L=4.8U W=4.8U AS=103.68P AD=11.52P PS=43.2U
+ PD=9.6U
* device instance $100 r180 *1 225.6,-319.2 MP
M$100 \$I36 \$13 VDD VDD MP L=4.8U W=9.6U AS=115.2P AD=69.12P PS=43.2U PD=24U
* device instance $101 r180 *1 206.4,-319.2 MP
M$101 VDD \$I35 \$I36 \$I36 MP L=4.8U W=9.6U AS=69.12P AD=115.2P PS=24U PD=43.2U
* device instance $102 m90 *1 168,-266.4 MN
M$102 \$I44 \$I35 VSS VSS MN L=4.8U W=4.8U AS=103.68P AD=11.52P PS=43.2U PD=9.6U
* device instance $103 m90 *1 158.4,-266.4 MN
M$103 \$I44 \$I34 \$11 \$11 MN L=4.8U W=4.8U AS=103.68P AD=11.52P PS=43.2U
+ PD=9.6U
* device instance $104 m90 *1 168,-247.2 MP
M$104 \$11 \$I35 VDD VDD MP L=4.8U W=9.6U AS=115.2P AD=69.12P PS=43.2U PD=24U
* device instance $105 m90 *1 148.8,-247.2 MP
M$105 VDD \$I34 \$11 \$11 MP L=4.8U W=9.6U AS=69.12P AD=115.2P PS=24U PD=43.2U
* device instance $106 m90 *1 225.6,-266.4 MN
M$106 \$I45 \$14 VSS VSS MN L=4.8U W=4.8U AS=103.68P AD=11.52P PS=43.2U PD=9.6U
* device instance $107 m90 *1 216,-266.4 MN
M$107 \$I45 \$13 \$I35 \$I35 MN L=4.8U W=4.8U AS=103.68P AD=11.52P PS=43.2U
+ PD=9.6U
* device instance $108 m90 *1 225.6,-247.2 MP
M$108 \$I35 \$14 VDD VDD MP L=4.8U W=9.6U AS=115.2P AD=69.12P PS=43.2U PD=24U
* device instance $109 m90 *1 206.4,-247.2 MP
M$109 VDD \$13 \$I35 \$I35 MP L=4.8U W=9.6U AS=69.12P AD=115.2P PS=24U PD=43.2U
* device instance $110 m90 *1 288,-266.4 MN
M$110 \$I46 \$I39 VSS VSS MN L=4.8U W=4.8U AS=103.68P AD=11.52P PS=43.2U PD=9.6U
* device instance $111 m90 *1 278.4,-266.4 MN
M$111 \$I46 \$I38 \$14 \$14 MN L=4.8U W=4.8U AS=103.68P AD=11.52P PS=43.2U
+ PD=9.6U
* device instance $112 m90 *1 288,-247.2 MP
M$112 \$14 \$I39 VDD VDD MP L=4.8U W=9.6U AS=115.2P AD=69.12P PS=43.2U PD=24U
* device instance $113 m90 *1 268.8,-247.2 MP
M$113 VDD \$I38 \$14 \$14 MP L=4.8U W=9.6U AS=69.12P AD=115.2P PS=24U PD=43.2U
* device instance $114 m90 *1 345.6,-266.4 MN
M$114 \$I47 \$18 VSS VSS MN L=4.8U W=4.8U AS=103.68P AD=11.52P PS=43.2U PD=9.6U
* device instance $115 m90 *1 336,-266.4 MN
M$115 \$I47 \$15 \$I39 \$I39 MN L=4.8U W=4.8U AS=103.68P AD=11.52P PS=43.2U
+ PD=9.6U
* device instance $116 m90 *1 345.6,-247.2 MP
M$116 \$I39 \$18 VDD VDD MP L=4.8U W=9.6U AS=115.2P AD=69.12P PS=43.2U PD=24U
* device instance $117 m90 *1 326.4,-247.2 MP
M$117 VDD \$15 \$I39 \$I39 MP L=4.8U W=9.6U AS=69.12P AD=115.2P PS=24U PD=43.2U
* device instance $118 r0 *1 384,-268.8 MN
M$118 \$15 \$24 VSS VSS MN L=4.8U W=4.8U AS=103.68P AD=103.68P PS=43.2U PD=43.2U
* device instance $119 r0 *1 384,-247.2 MP
M$119 \$15 \$24 VDD VDD MP L=4.8U W=9.6U AS=115.2P AD=115.2P PS=43.2U PD=43.2U
* device instance $120 m0 *1 384,-297.6 MN
M$120 \$13 \$15 VSS VSS MN L=4.8U W=4.8U AS=103.68P AD=103.68P PS=43.2U PD=43.2U
* device instance $121 m0 *1 384,-319.2 MP
M$121 \$13 \$15 VDD VDD MP L=4.8U W=9.6U AS=115.2P AD=115.2P PS=43.2U PD=43.2U
* device instance $122 r180 *1 168,-513.6 MN
M$122 \$I54 \$I50 VSS VSS MN L=4.8U W=4.8U AS=103.68P AD=11.52P PS=43.2U PD=9.6U
* device instance $123 r180 *1 158.4,-513.6 MN
M$123 \$I54 MINIPAD \$I48 \$I48 MN L=4.8U W=4.8U AS=103.68P AD=11.52P PS=43.2U
+ PD=9.6U
* device instance $124 r180 *1 168,-532.8 MP
M$124 \$I48 \$I50 VDD VDD MP L=4.8U W=9.6U AS=115.2P AD=69.12P PS=43.2U PD=24U
* device instance $125 r180 *1 148.8,-532.8 MP
M$125 VDD MINIPAD \$I48 \$I48 MP L=4.8U W=9.6U AS=69.12P AD=115.2P PS=24U
+ PD=43.2U
* device instance $126 r180 *1 345.6,-513.6 MN
M$126 \$I55 \$3 VSS VSS MN L=4.8U W=4.8U AS=103.68P AD=11.52P PS=43.2U PD=9.6U
* device instance $127 r180 *1 336,-513.6 MN
M$127 \$I55 \$I53 \$I51 \$I51 MN L=4.8U W=4.8U AS=103.68P AD=11.52P PS=43.2U
+ PD=9.6U
* device instance $128 r180 *1 345.6,-532.8 MP
M$128 \$I51 \$3 VDD VDD MP L=4.8U W=9.6U AS=115.2P AD=69.12P PS=43.2U PD=24U
* device instance $129 r180 *1 326.4,-532.8 MP
M$129 VDD \$I53 \$I51 \$I51 MP L=4.8U W=9.6U AS=69.12P AD=115.2P PS=24U PD=43.2U
* device instance $130 r180 *1 288,-513.6 MN
M$130 \$I56 \$I51 VSS VSS MN L=4.8U W=4.8U AS=103.68P AD=11.52P PS=43.2U PD=9.6U
* device instance $131 r180 *1 278.4,-513.6 MN
M$131 \$I56 \$4 \$I52 \$I52 MN L=4.8U W=4.8U AS=103.68P AD=11.52P PS=43.2U
+ PD=9.6U
* device instance $132 r180 *1 288,-532.8 MP
M$132 \$I52 \$I51 VDD VDD MP L=4.8U W=9.6U AS=115.2P AD=69.12P PS=43.2U PD=24U
* device instance $133 r180 *1 268.8,-532.8 MP
M$133 VDD \$4 \$I52 \$I52 MP L=4.8U W=9.6U AS=69.12P AD=115.2P PS=24U PD=43.2U
* device instance $134 r180 *1 225.6,-513.6 MN
M$134 \$I57 \$I3 VSS VSS MN L=4.8U W=4.8U AS=103.68P AD=11.52P PS=43.2U PD=9.6U
* device instance $135 r180 *1 216,-513.6 MN
M$135 \$I57 \$I49 \$I50 \$I50 MN L=4.8U W=4.8U AS=103.68P AD=11.52P PS=43.2U
+ PD=9.6U
* device instance $136 r180 *1 225.6,-532.8 MP
M$136 \$I50 \$I3 VDD VDD MP L=4.8U W=9.6U AS=115.2P AD=69.12P PS=43.2U PD=24U
* device instance $137 r180 *1 206.4,-532.8 MP
M$137 VDD \$I49 \$I50 \$I50 MP L=4.8U W=9.6U AS=69.12P AD=115.2P PS=24U PD=43.2U
* device instance $138 m90 *1 168,-480 MN
M$138 \$I58 \$I49 VSS VSS MN L=4.8U W=4.8U AS=103.68P AD=11.52P PS=43.2U PD=9.6U
* device instance $139 m90 *1 158.4,-480 MN
M$139 \$I58 \$I48 MINIPAD MINIPAD MN L=4.8U W=4.8U AS=103.68P AD=11.52P
+ PS=43.2U PD=9.6U
* device instance $140 m90 *1 168,-460.8 MP
M$140 MINIPAD \$I49 VDD VDD MP L=4.8U W=9.6U AS=115.2P AD=69.12P PS=43.2U PD=24U
* device instance $141 m90 *1 148.8,-460.8 MP
M$141 VDD \$I48 MINIPAD MINIPAD MP L=4.8U W=9.6U AS=69.12P AD=115.2P PS=24U
+ PD=43.2U
* device instance $142 m90 *1 225.6,-480 MN
M$142 \$I59 \$4 VSS VSS MN L=4.8U W=4.8U AS=103.68P AD=11.52P PS=43.2U PD=9.6U
* device instance $143 m90 *1 216,-480 MN
M$143 \$I59 \$I3 \$I49 \$I49 MN L=4.8U W=4.8U AS=103.68P AD=11.52P PS=43.2U
+ PD=9.6U
* device instance $144 m90 *1 225.6,-460.8 MP
M$144 \$I49 \$4 VDD VDD MP L=4.8U W=9.6U AS=115.2P AD=69.12P PS=43.2U PD=24U
* device instance $145 m90 *1 206.4,-460.8 MP
M$145 VDD \$I3 \$I49 \$I49 MP L=4.8U W=9.6U AS=69.12P AD=115.2P PS=24U PD=43.2U
* device instance $146 m90 *1 288,-480 MN
M$146 \$I60 \$I53 VSS VSS MN L=4.8U W=4.8U AS=103.68P AD=11.52P PS=43.2U PD=9.6U
* device instance $147 m90 *1 278.4,-480 MN
M$147 \$I60 \$I52 \$4 \$4 MN L=4.8U W=4.8U AS=103.68P AD=11.52P PS=43.2U PD=9.6U
* device instance $148 m90 *1 288,-460.8 MP
M$148 \$4 \$I53 VDD VDD MP L=4.8U W=9.6U AS=115.2P AD=69.12P PS=43.2U PD=24U
* device instance $149 m90 *1 268.8,-460.8 MP
M$149 VDD \$I52 \$4 \$4 MP L=4.8U W=9.6U AS=69.12P AD=115.2P PS=24U PD=43.2U
* device instance $150 m90 *1 345.6,-480 MN
M$150 \$I61 \$I1 VSS VSS MN L=4.8U W=4.8U AS=103.68P AD=11.52P PS=43.2U PD=9.6U
* device instance $151 m90 *1 336,-480 MN
M$151 \$I61 \$3 \$I53 \$I53 MN L=4.8U W=4.8U AS=103.68P AD=11.52P PS=43.2U
+ PD=9.6U
* device instance $152 m90 *1 345.6,-460.8 MP
M$152 \$I53 \$I1 VDD VDD MP L=4.8U W=9.6U AS=115.2P AD=69.12P PS=43.2U PD=24U
* device instance $153 m90 *1 326.4,-460.8 MP
M$153 VDD \$3 \$I53 \$I53 MP L=4.8U W=9.6U AS=69.12P AD=115.2P PS=24U PD=43.2U
* device instance $154 r0 *1 384,-482.4 MN
M$154 \$3 \$24 VSS VSS MN L=4.8U W=4.8U AS=103.68P AD=103.68P PS=43.2U PD=43.2U
* device instance $155 r0 *1 384,-460.8 MP
M$155 \$3 \$24 VDD VDD MP L=4.8U W=9.6U AS=115.2P AD=115.2P PS=43.2U PD=43.2U
* device instance $156 m0 *1 384,-511.2 MN
M$156 \$I3 \$3 VSS VSS MN L=4.8U W=4.8U AS=103.68P AD=103.68P PS=43.2U PD=43.2U
* device instance $157 m0 *1 384,-532.8 MP
M$157 \$I3 \$3 VDD VDD MP L=4.8U W=9.6U AS=115.2P AD=115.2P PS=43.2U PD=43.2U
* device instance $158 r180 *1 417.6,-88.8 MN
M$158 \$I66 MINIPAD VSS VSS MN L=4.8U W=4.8U AS=103.68P AD=11.52P PS=43.2U
+ PD=9.6U
* device instance $159 r180 *1 408,-88.8 MN
M$159 \$I66 \$18 \$I63 \$I63 MN L=4.8U W=4.8U AS=103.68P AD=11.52P PS=43.2U
+ PD=9.6U
* device instance $160 r180 *1 417.6,-108 MP
M$160 \$I63 MINIPAD VDD VDD MP L=4.8U W=9.6U AS=115.2P AD=69.12P PS=43.2U PD=24U
* device instance $161 r180 *1 398.4,-108 MP
M$161 VDD \$18 \$I63 \$I63 MP L=4.8U W=9.6U AS=69.12P AD=115.2P PS=24U PD=43.2U
* device instance $162 r180 *1 360,-88.8 MN
M$162 \$I67 \$I63 VSS VSS MN L=4.8U W=4.8U AS=103.68P AD=11.52P PS=43.2U PD=9.6U
* device instance $163 r180 *1 350.4,-88.8 MN
M$163 \$I67 \$18 \$I62 \$I62 MN L=4.8U W=4.8U AS=103.68P AD=11.52P PS=43.2U
+ PD=9.6U
* device instance $164 r180 *1 360,-108 MP
M$164 \$I62 \$I63 VDD VDD MP L=4.8U W=9.6U AS=115.2P AD=69.12P PS=43.2U PD=24U
* device instance $165 r180 *1 340.8,-108 MP
M$165 VDD \$18 \$I62 \$I62 MP L=4.8U W=9.6U AS=69.12P AD=115.2P PS=24U PD=43.2U
* device instance $166 m90 *1 360,-57.6 MN
M$166 \$I68 \$I64 VSS VSS MN L=4.8U W=4.8U AS=103.68P AD=11.52P PS=43.2U PD=9.6U
* device instance $167 m90 *1 350.4,-57.6 MN
M$167 \$I68 \$I62 \$I65 \$I65 MN L=4.8U W=4.8U AS=103.68P AD=11.52P PS=43.2U
+ PD=9.6U
* device instance $168 m90 *1 360,-38.4 MP
M$168 \$I65 \$I64 VDD VDD MP L=4.8U W=9.6U AS=115.2P AD=69.12P PS=43.2U PD=24U
* device instance $169 m90 *1 340.8,-38.4 MP
M$169 VDD \$I62 \$I65 \$I65 MP L=4.8U W=9.6U AS=69.12P AD=115.2P PS=24U PD=43.2U
* device instance $170 m90 *1 417.6,-57.6 MN
M$170 \$I69 MINIPAD VSS VSS MN L=4.8U W=4.8U AS=103.68P AD=11.52P PS=43.2U
+ PD=9.6U
* device instance $171 m90 *1 408,-57.6 MN
M$171 \$I69 \$I63 \$I64 \$I64 MN L=4.8U W=4.8U AS=103.68P AD=11.52P PS=43.2U
+ PD=9.6U
* device instance $172 m90 *1 417.6,-38.4 MP
M$172 \$I64 MINIPAD VDD VDD MP L=4.8U W=9.6U AS=115.2P AD=69.12P PS=43.2U PD=24U
* device instance $173 m90 *1 398.4,-38.4 MP
M$173 VDD \$I63 \$I64 \$I64 MP L=4.8U W=9.6U AS=69.12P AD=115.2P PS=24U PD=43.2U
* device instance $174 m0 *1 278.4,-57.6 MN
M$174 \$28 RST VSS VSS MN L=4.8U W=4.8U AS=103.68P AD=57.6P PS=43.2U PD=24U
* device instance $175 m0 *1 297.6,-57.6 MN
M$175 VSS \$I65 \$28 \$28 MN L=4.8U W=4.8U AS=57.6P AD=103.68P PS=24U PD=43.2U
* device instance $176 m0 *1 278.4,-93.6 MP
M$176 \$I70 RST VDD VDD MP L=4.8U W=38.4U AS=460.8P AD=92.16P PS=100.8U PD=43.2U
* device instance $177 m0 *1 288,-93.6 MP
M$177 \$28 \$I65 \$I70 \$I70 MP L=4.8U W=38.4U AS=92.16P AD=460.8P PS=43.2U
+ PD=100.8U
.ENDS top_layout_langsun
